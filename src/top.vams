`include "src/ams-models/res.va"
`include "src/ams-models/mos_level1.va"
`include "src/ams-models/mos_level1p.va"
`include "src/ams-models/cap.va"
`include "src/ams-models/ind.va"
`include "src/vsrc.vams"
`include "src/ams-models/diode_simple.va"
`include "src/vpulse.va"
`include "src/freqmeasure.vams"
`include "src/vramp.va"

module top();

electrical vcovgnd, o1, o2, ondc, vdd, vctrl, cme, cin, gnd, d, tmid;
ground gnd;
wreal s, maxv;
reg clk;
  integer i;

initial clk = 0;
always #1 clk <= !clk;

  voltage probe_freq;
freqmeasure fm(ondc, gnd, s, clk, maxv);

//VCO
vsrc #(3) v0(vdd, gnd);
//drain, gate, source, body

mos_level1 i4(o1, o2, vcovgnd, vcovgnd);
mos_level1 i3(o2, o1, vcovgnd, vcovgnd);
cap #(500f) i25(o1, o2);
ind #(1n) i6(o1, vdd);
ind #(1n) i5(o2, vdd);

//CTRL
//vsrc #(3) vc(vctrl, gnd);
vramp #(.vs(-3), .vf(3), .tt(100n)) vr(vctrl);
cap #(500f) dcblock(o2, ondc);

diode_simple i31(vctrl, o1);
diode_simple i30(vctrl, o2);

//CURR_SRC
mos_level1 i33(vcovgnd, vdd, gnd, gnd);
mos_level1 i34(cme, vdd, gnd, gnd);
res#(3K) i35(cme, vdd);

//I TRIGGER
mos_level1 i32(o1, cin, gnd, gnd);
vpulse#(.mag(3), .td(1n), .tt(1p), .tw(1n)) vp(cin, gnd);

//DIGITIZER
//drain, gate, source, body

mos_level1p cp1(tmid, ondc, vdd, vdd);
mos_level1 cn1(tmid, ondc, gnd, gnd);

initial begin
  for(i=0;i<100;i=i+1) begin
    #1;
    $display("freq s: %e, mag : %e", s, maxv);
  end
  $finish;
end
analog
    V(probe_freq) <+ s;

endmodule

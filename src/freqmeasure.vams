module freqmeasure(e1, gnd, freq, clk);

  electrical e1, gnd;
  ground gnd;
  logic clk;
  input e1, gnd, clk;

  wreal freq;
  output freq;

  real t, s, a, f, o;
  real q[9:0];

integer i, k, rdy;

  analog begin

    @(initial_step) begin
      t=0;
      s=0;
      i=0;
      k=0;
      rdy=0;
      a=0;
      f=0;
    end

    @(cross(V(e1, gnd), +1)) begin
      s = $abstime - t;
      t = $abstime;
      i=i+1;
      if(i>9) begin
        i=0;
        rdy=1;
      end
      q[i] = s;
      if(rdy) begin
        for(k=0;k<10;k=k+1) a = a + q[k];
        f = 10/a;
        a = 0;
      end
    end

  end

  always @(posedge clk) begin
    o = f;
  end

  assign freq = o;

endmodule
